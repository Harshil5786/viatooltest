# Ansys Electronics Desktop project, version 2023.1
materials:
  vacuum: permittivity=1
  A21_BPK_CU_4p3e7: permittivity=1 permeability=1 conductivity=43000000
  A21_BPK_core: permittivity=2.83338+0.00163949*ln((2.53303e+22+Freq*Freq)/(7.82919e+08+Freq*Freq)) permeability=1 conductivity=1e-12+1.82418e-13*Freq*(atan(Freq/27980.7)-atan(Freq/1.59155e+11))
  A21_BPK_prepreg: permittivity=2.73307+0.00166985*ln((2.53303e+22+Freq*Freq)/(7.90898e+08+Freq*Freq)) permeability=1 conductivity=1e-12+1.85796e-13*Freq*(atan(Freq/28122.9)-atan(Freq/1.59155e+11))
  A21_BPK_smask: permittivity=3.67594+0.0319588*ln((2.53303e+22+Freq*Freq)/(8.22935e+09+Freq*Freq)) permeability=1 conductivity=1e-12+3.5559e-12*Freq*(atan(Freq/90715.7)-atan(Freq/1.59155e+11))
  air: permittivity=1 permeability=1.0000004
surface materials:
  Steel-oxidised-surface

design HFSS_DZL (HFSS, HFSS Modal Network, model units mil)
options: Allow_Material_Override Save_Adaptive_support_files
geometry:
  airbox [air] = box(corner=(0mil, 0mil, -9.76mil), size=(400mil, 400mil, 117.12mil))
  UNNAMED_037 [A21_BPK_smask] = box(corner=(0mil, 0mil, 0mil), size=(400mil, 400mil, 0.5mil))
  BOTTOM_fill [A21_BPK_smask] = box(corner=(0mil, 0mil, 0.5mil), size=(400mil, 400mil, 2.3mil))
  UNNAMED_035 [A21_BPK_prepreg] = box(corner=(0mil, 0mil, 2.8mil), size=(400mil, 400mil, 2.7mil))
  L17_fill [A21_BPK_prepreg] = box(corner=(0mil, 0mil, 5.5mil), size=(400mil, 400mil, 1.2mil))
  UNNAMED_033 [A21_BPK_core] = box(corner=(0mil, 0mil, 6.7mil), size=(400mil, 400mil, 4mil))
  L16_fill [A21_BPK_prepreg] = box(corner=(0mil, 0mil, 10.7mil), size=(400mil, 400mil, 1.2mil))
  UNNAMED_031 [A21_BPK_prepreg] = box(corner=(0mil, 0mil, 11.9mil), size=(400mil, 400mil, 5mil))
  L15_fill [A21_BPK_prepreg] = box(corner=(0mil, 0mil, 16.9mil), size=(400mil, 400mil, 1.2mil))
  UNNAMED_029 [A21_BPK_core] = box(corner=(0mil, 0mil, 18.1mil), size=(400mil, 400mil, 4mil))
  L14_fill [A21_BPK_prepreg] = box(corner=(0mil, 0mil, 22.1mil), size=(400mil, 400mil, 1.2mil))
  UNNAMED_027 [A21_BPK_prepreg] = box(corner=(0mil, 0mil, 23.3mil), size=(400mil, 400mil, 5mil))
  L13_fill [A21_BPK_prepreg] = box(corner=(0mil, 0mil, 28.3mil), size=(400mil, 400mil, 1.2mil))
  UNNAMED_025 [A21_BPK_core] = box(corner=(0mil, 0mil, 29.5mil), size=(400mil, 400mil, 4mil))
  L12_fill [A21_BPK_prepreg] = box(corner=(0mil, 0mil, 33.5mil), size=(400mil, 400mil, 1.2mil))
  UNNAMED_023 [A21_BPK_prepreg] = box(corner=(0mil, 0mil, 34.7mil), size=(400mil, 400mil, 5mil))
  L11_fill [A21_BPK_prepreg] = box(corner=(0mil, 0mil, 39.7mil), size=(400mil, 400mil, 1.2mil))
  UNNAMED_021 [A21_BPK_core] = box(corner=(0mil, 0mil, 40.9mil), size=(400mil, 400mil, 3mil))
  L10_fill [A21_BPK_prepreg] = box(corner=(0mil, 0mil, 43.9mil), size=(400mil, 400mil, 2.4mil))
  UNNAMED_019 [A21_BPK_prepreg] = box(corner=(0mil, 0mil, 46.3mil), size=(400mil, 400mil, 5mil))
  L9_fill [A21_BPK_prepreg] = box(corner=(0mil, 0mil, 51.3mil), size=(400mil, 400mil, 2.4mil))
  UNNAMED_017 [A21_BPK_core] = box(corner=(0mil, 0mil, 53.7mil), size=(400mil, 400mil, 3mil))
  L8_fill [A21_BPK_prepreg] = box(corner=(0mil, 0mil, 56.7mil), size=(400mil, 400mil, 1.2mil))
  UNNAMED_015 [A21_BPK_prepreg] = box(corner=(0mil, 0mil, 57.9mil), size=(400mil, 400mil, 5mil))
  L7_fill [A21_BPK_prepreg] = box(corner=(0mil, 0mil, 62.9mil), size=(400mil, 400mil, 1.2mil))
  UNNAMED_013 [A21_BPK_core] = box(corner=(0mil, 0mil, 64.1mil), size=(400mil, 400mil, 4mil))
  L6_fill [A21_BPK_prepreg] = box(corner=(0mil, 0mil, 68.1mil), size=(400mil, 400mil, 1.2mil))
  UNNAMED_011 [A21_BPK_prepreg] = box(corner=(0mil, 0mil, 69.3mil), size=(400mil, 400mil, 5mil))
  L5_fill [A21_BPK_prepreg] = box(corner=(0mil, 0mil, 74.3mil), size=(400mil, 400mil, 1.2mil))
  UNNAMED_009 [A21_BPK_core] = box(corner=(0mil, 0mil, 75.5mil), size=(400mil, 400mil, 4mil))
  L4_fill [A21_BPK_prepreg] = box(corner=(0mil, 0mil, 79.5mil), size=(400mil, 400mil, 1.2mil))
  UNNAMED_007 [A21_BPK_prepreg] = box(corner=(0mil, 0mil, 80.7mil), size=(400mil, 400mil, 5mil))
  L3_fill [A21_BPK_prepreg] = box(corner=(0mil, 0mil, 85.7mil), size=(400mil, 400mil, 1.2mil))
  UNNAMED_005 [A21_BPK_core] = box(corner=(0mil, 0mil, 86.9mil), size=(400mil, 400mil, 4mil))
  L2_fill [A21_BPK_prepreg] = box(corner=(0mil, 0mil, 90.9mil), size=(400mil, 400mil, 1.2mil))
  UNNAMED_003 [A21_BPK_prepreg] = box(corner=(0mil, 0mil, 92.1mil), size=(400mil, 400mil, 2.7mil))
  TOP_fill [A21_BPK_smask] = box(corner=(0mil, 0mil, 94.8mil), size=(400mil, 400mil, 2.3mil))
  UNNAMED_001 [A21_BPK_smask] = box(corner=(0mil, 0mil, 97.1mil), size=(400mil, 400mil, 0.5mil))
  test_via1_drill [A21_BPK_CU_4p3e7] = cylinder(axis=Z, base_centre=(150mil, 100mil, 0.5mil), radius=8mil, height=96.6mil, segments=16)
  test_via1_top_pad = cylinder(axis=Z, base_centre=(150mil, 100mil, 94.8mil), radius=16mil, height=2.3mil, segments=16)
  test_via1_in_trace_path = polyline((150mil, 100mil, 94.8mil) (150mil, 130mil, 94.8mil))
  test_via1_in_trace = polyline(y=130mil, xz in mil: (153, 94.8) (147, 94.8) (147, 97.1) (153, 97.1) (153, 94.8), closed, covered)
  test_via1_in_trace.sweep_along_path(test_via1_in_trace_path)
  test_via1_out_trace_path = polyline((150mil, 100mil, 0.5mil) (150mil, 70mil, 0.5mil))
  test_via1_out_trace = polyline(y=70mil, xz in mil: (153, 0.5) (147, 0.5) (147, 2.8) (153, 2.8) (153, 0.5), closed, covered)
  test_via1_out_trace.sweep_along_path(test_via1_out_trace_path)
  Port_1 = polyline(y=130mil, xz in mil: (153, 94.8) (147, 94.8) (147, 92.1) (153, 92.1) (153, 94.8), closed, covered)
  Port_2 = polyline(y=70mil, xz in mil: (153, 2.8) (147, 2.8) (147, 5.5) (153, 5.5) (153, 2.8), closed, covered)
  test_via1_backdrill = cylinder(axis=Z, base_centre=(150mil, 100mil, 0.5mil), radius=40mil, height=-4mil, segments=16)
  test_via1_backdrill_11 = test_via1_backdrill.copy()
  test_via1_drill.subtract(test_via1_backdrill_11)
  test_via1_backdrill_12 = test_via1_backdrill.copy()
  test_via1_top_pad.subtract(test_via1_backdrill_12)
  test_via1_backdrill_13 = test_via1_backdrill.copy()
  test_via1_in_trace.subtract(test_via1_backdrill_13)
  test_via1_out_trace.subtract(test_via1_backdrill)
  test_via1_drill.unite(test_via1_top_pad, test_via1_in_trace, test_via1_out_trace)
  test_via2_drill [A21_BPK_CU_4p3e7] = cylinder(axis=Z, base_centre=(200mil, 50mil, 0.5mil), radius=8mil, height=96.6mil, segments=16)
  test_via2_top_pad = cylinder(axis=Z, base_centre=(200mil, 50mil, 94.8mil), radius=16mil, height=2.3mil, segments=16)
  test_via2_in_trace_path = polyline((200mil, 50mil, 94.8mil) (200mil, 80mil, 94.8mil))
  test_via2_in_trace = polyline(y=80mil, xz in mil: (203, 94.8) (197, 94.8) (197, 97.1) (203, 97.1) (203, 94.8), closed, covered)
  test_via2_in_trace.sweep_along_path(test_via2_in_trace_path)
  test_via2_out_trace_path = polyline((200mil, 50mil, 0.5mil) (200mil, 20mil, 0.5mil))
  test_via2_out_trace = polyline(y=20mil, xz in mil: (203, 0.5) (197, 0.5) (197, 2.8) (203, 2.8) (203, 0.5), closed, covered)
  test_via2_out_trace.sweep_along_path(test_via2_out_trace_path)
  Port_3 = polyline(y=80mil, xz in mil: (203, 94.8) (197, 94.8) (197, 92.1) (203, 92.1) (203, 94.8), closed, covered)
  Port_4 = polyline(y=20mil, xz in mil: (203, 2.8) (197, 2.8) (197, 5.5) (203, 5.5) (203, 2.8), closed, covered)
  test_via2_backdrill = cylinder(axis=Z, base_centre=(200mil, 50mil, 0.5mil), radius=40mil, height=0mil, segments=16)
  test_via2_backdrill_11 = test_via2_backdrill.copy()
  test_via2_drill.subtract(test_via2_backdrill_11)
  test_via2_backdrill_12 = test_via2_backdrill.copy()
  test_via2_top_pad.subtract(test_via2_backdrill_12)
  test_via2_backdrill_13 = test_via2_backdrill.copy()
  test_via2_in_trace.subtract(test_via2_backdrill_13)
  test_via2_out_trace.subtract(test_via2_backdrill)
  test_via2_drill.unite(test_via2_top_pad, test_via2_in_trace, test_via2_out_trace)
  GND [A21_BPK_CU_4p3e7] = imported_body()
boundaries and excitations:
  ABox_Rad: Radiation Objects=airbox
  1: Lumped Port Objects=Port_1 LumpedPortType=Modal Modes{Mode1{IntLine{(147, 130, 93.45) -> (153, 130, 93.45)} CharImp=Zpi RenormImp=50ohm}} Impedance=50ohm
  2: Lumped Port Objects=Port_2 LumpedPortType=Modal Modes{Mode1{IntLine{(147, 70, 4.15) -> (153, 70, 4.15)} CharImp=Zpi RenormImp=50ohm}} Impedance=50ohm
  3: Lumped Port Objects=Port_3 LumpedPortType=Modal Modes{Mode1{IntLine{(197, 80, 93.45) -> (203, 80, 93.45)} CharImp=Zpi RenormImp=50ohm}} Impedance=50ohm
  4: Lumped Port Objects=Port_4 LumpedPortType=Modal Modes{Mode1{IntLine{(197, 20, 4.15) -> (203, 20, 4.15)} CharImp=Zpi RenormImp=50ohm}} Impedance=50ohm
setups:
  test_def: HfssDriven MultipleAdaptiveFreqsSetup{Low=0GHz High=30GHz} MaxDeltaS=0.02 MaximumPasses=22 MinimumPasses=1 MinimumConvergedPasses=3 PercentRefinement=30 BasisOrder=-1 Target=0.666667 PortAccuracy=2 DrivenSolverType="Direct Solver" SaveAnyFields=false
    sweep sweep_dbg_40G: 0GHz to 40GHz step 0.1GHz; Type=Interpolating InterpTolerance=0.5 InterpMaxSolns=250 MinSolvedFreq=0.01GHz InterpUsePortImped=false PassivityErrorTolerance=0.0001
source amplitudes:
  1:1: 1W 0deg
  2:1, 3:1, 4:1: 0W 0deg
